# Ansys Electronics Desktop project, version 2023.2
materials:
  vacuum: permittivity=1

design HFSSDesign1 (HFSS, HFSS Terminal Network, model units mm)
geometry:
  Box [vacuum] = box(corner=(-1mm, -1mm, -1mm), size=(2mm, 2mm, 2mm))
  Port = rectangle(corner=(-0.0025mm, 0.015mm, 0mm), x_size=0.005mm, y_size=-0.005mm)
  patch_antenna [vacuum] = imported_body()
  coordinate_system RelativeCS1 = origin=(0mm, 0mm, 100mm) x=(1mm, 0mm, 0mm) y=(0mm, 1mm, 0mm)
boundaries and excitations:
  PerfE1: Perfect E Objects=patch_antenna
  Rad1: Radiation Objects=Box
  1: Lumped Port Objects=Port LumpedPortType=Modal Modes{Mode1{IntLine{(0, 0.015, 0) -> (0, 0.01, 0)} CharImp=Zpi RenormImp=50ohm}} Impedance=50ohm
setups:
  Setup1: HfssDriven Frequency=60GHz MaxDeltaS=0.02 MaximumPasses=18 MinimumPasses=1 MinimumConvergedPasses=1 PercentRefinement=30 BasisOrder=1 PortAccuracy=2 DrivenSolverType="Direct Solver"
    sweep Sweep: 30GHz to 90GHz, 401 points; Type=Discrete SaveFields SaveRadFields
source amplitudes:
  1:1: 1V 0deg
radiation setups:
  Infinite Sphere1: Infinite Sphere Theta=-180deg..180deg step 2deg Phi=0deg..90deg step 90deg
  Rectangle1: Near Rectangle  Length=100dm Width=100dm LengthSamples=100 WidthSamples=100 CoordSystem=RelativeCS1
reports:
  Zig Zag Monopole Antenna S parameter Plot: dB(S(1,1)) vs Freq on Setup1 : Sweep; markers m1 at 57GHz
  Gain Plot 1: GainTotal vs Freq on Setup1 : Sweep, Infinite Sphere1 [Phi=0deg Theta=0deg]
  System Gain Plot 1: dB(SystemGainTotal) vs Freq on Setup1 : LastAdaptive, Infinite Sphere1 [Phi=0deg Theta=0deg]
  Gain Plot: dB(SystemGainTotal) vs Freq on Setup1 : Sweep, Infinite Sphere1 [Phi=0deg Theta=0deg]; markers m1 at 60GHz
  Port Zo Plot 1: re(Zo(1)) vs Freq on Setup1 : Sweep
  VSWR Plot 1: VSWR(1) vs Freq on Setup1 : Sweep
  VSWR Plot 2: dB(VSWR(1)) vs Freq on Setup1 : Sweep; markers m1 at 57.45GHz, m2 at 58.05GHz, m3 at 58.95GHz, m4 at 59.7GHz, m5 at 60.3GHz
  3-D Polar Plot of Gain: dB(GainTotal) vs Phi, Theta on Setup1 : LastAdaptive, Infinite Sphere1 [Freq=60GHz]
  Gain Plot 2: dB(GainTotal) vs Theta on Setup1 : LastAdaptive, Infinite Sphere1 [Phi=0deg Freq=60GHz]
  Gain Plot 3: dB(GainTotal) vs Phi on Setup1 : LastAdaptive, Infinite Sphere1 [Theta=0deg Freq=60GHz]
  Gain Plot 4: dB(GainTotal) vs Theta on Setup1 : LastAdaptive, Infinite Sphere1 [Phi=90deg Freq=60GHz]
  Gain Plot 5: dB(GainTotal) vs Theta on Setup1 : LastAdaptive, Infinite Sphere1 [Phi=0deg,90deg Freq=60GHz]
  Gain Plot 6: dB(GainTotal) vs Theta on Setup1 : LastAdaptive, Infinite Sphere1 [Phi=0deg Freq=60GHz]
  Gain Plot 7: dB(GainTotal) vs Theta on Setup1 : LastAdaptive, Infinite Sphere1 [Phi=0deg,90deg Freq=60GHz]
  Gain Plot 8: dB(GainTotal) vs Theta on Setup1 : LastAdaptive, Infinite Sphere1 [Phi=90deg Freq=60GHz]
  Gain Plot 9: dB(GainTotal) vs Theta on Setup1 : LastAdaptive, Infinite Sphere1 [Phi=0deg Freq=60GHz]
  Radiation Pattern at Phi = 0': dB(GainTotal) vs Theta on Setup1 : LastAdaptive, Infinite Sphere1 [Phi=all Freq=60GHz]; markers m1 at 90deg, m2 at 0deg, m3 at 180deg, m4 at -90deg, m5 at 90deg, m6 at -88deg
  Power Plot at Plane z=10cm: re(NearEZ)*0.000025 vs _u, _v on Setup1 : LastAdaptive [Freq=60GHz]
