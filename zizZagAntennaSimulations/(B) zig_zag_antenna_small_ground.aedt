# Ansys Electronics Desktop project, version 2023.2
materials:
  vacuum: permittivity=1
  air: permittivity=1.0006 permeability=1.0000004

design HFSSDesign1 (HFSS, HFSS Terminal Network, model units mm)
geometry:
  port = rectangle(corner=(-0.0025mm, 0.015mm, 0mm), x_size=0.005mm, y_size=-0.005mm)
  box [air] = box(corner=(-0.5mm, 1.6mm, 0.3mm), size=(1mm, -2mm, -0.6mm))
  Polyline1 [vacuum] = imported_body()
  coordinate_system RelativeCS1 = origin=(0mm, 0mm, 100mm) x=(1mm, 0mm, 0mm) y=(0mm, 1mm, 0mm)
boundaries and excitations:
  Rad1: Radiation Objects=box
  PerfE1: Perfect E Objects=Polyline1
  1: Lumped Port Objects=port LumpedPortType=Modal Modes{Mode1{IntLine{(0, 0.015, 0) -> (0, 0.01, 0)} CharImp=Zpi RenormImp=50ohm}} Impedance=50ohm
setups:
  Setup1: HfssDriven Frequency=60GHz MaxDeltaS=0.02 MaximumPasses=6 MinimumPasses=1 MinimumConvergedPasses=1 PercentRefinement=30 BasisOrder=1 PortAccuracy=2 DrivenSolverType="Direct Solver"
    sweep Sweep: 30GHz to 90GHz, 401 points; Type=Discrete SaveFields SaveRadFields
source amplitudes:
  1:1: 1V 0deg
radiation setups:
  Infinite Sphere1: Infinite Sphere Theta=-180deg..180deg step 10deg Phi=0deg..360deg step 10deg
  Rectangle1: Near Rectangle  Length=100cm Width=100cm LengthSamples=100 WidthSamples=100 CoordSystem=RelativeCS1
reports:
  S Parameter Plot 1: dB(S(1,1)) vs Freq on Setup1 : Sweep; markers m1 at 62.4GHz, m2 at 56.55GHz, m3 at 68.85GHz, MY1 at y=-2.9893
  VSWR Plot 1: VSWR(1) vs Freq on Setup1 : Sweep; markers m1 at 60GHz
  Gain Plot 1: dB(GainTotal) vs Freq on Setup1 : Sweep, Infinite Sphere1 [Phi=0deg Theta=0deg]; markers m1 at 60GHz, m2 at 80.1GHz, m3 at 69.9GHz
  Gain Plot: dB(SystemGainTotal) vs Freq on Setup1 : Sweep, Infinite Sphere1 [Phi=0deg Theta=0deg]; markers m1 at 60GHz
  3-D Gain Plot: dB(GainTotal) vs Phi, Theta on Setup1 : LastAdaptive, Infinite Sphere1 [Freq=60GHz]
  Near Poynting Plot 1_Power_Density: re(NearPoyntingZ) vs _u, _v on Setup1 : LastAdaptive [Freq=60GHz]
  Power Plot of Plane z=10 cm: re(NearPoyntingZ)*0.000025 vs _u, _v on Setup1 : LastAdaptive [Freq=60GHz]
  power_in_DB: 10*log10(re(NearPoyntingZ)*0.000025) vs _u, _v on Setup1 : LastAdaptive [Freq=60GHz]
  power_in_mdB: 10*log10(re(NearPoyntingZ)*0.000025)+30 vs _u, _v on Setup1 : LastAdaptive [Freq=60GHz]
  Small GND S Parameter Plot: dB(S(1,1)) vs Freq on Setup1 : Sweep; markers m1 at 62.55GHz
  Gain Plot 2: GainTotal vs Theta on Setup1 : LastAdaptive, Infinite Sphere1 [Phi=0deg Freq=60GHz]
  Gain Plot 3: GainTotal vs Phi on Setup1 : LastAdaptive, Infinite Sphere1 [Theta=0deg Freq=60GHz]
  Gain Plot 4: dB(GainTotal) vs Phi on Setup1 : LastAdaptive, Infinite Sphere1 [Theta=0deg Freq=60GHz]
  Gain Plot 5: dB(GainTotal) vs Theta on Setup1 : LastAdaptive, Infinite Sphere1 [Phi=0deg Freq=60GHz]
  Gain Plot 6: dB(GainTotal) vs Phi on Setup1 : LastAdaptive, Infinite Sphere1 [Theta=0deg Freq=60GHz]
  Gain Plot 7: dB(GainTotal) vs Theta on Setup1 : LastAdaptive, Infinite Sphere1 [Phi=0deg Freq=60GHz]
  Radiation Pattern in phi = 0': dB(GainTotal) vs Theta on Setup1 : LastAdaptive, Infinite Sphere1 [Phi=90deg Freq=60GHz]; markers m1 at 0deg, m2 at -90deg, m3 at 90deg, m4 at 180deg
  Gain Plot 8: dB(GainTotal) vs Theta on Setup1 : LastAdaptive, Infinite Sphere1 [Phi=0deg Freq=60GHz]
  Gain Plot 9: dB(GainTotal) vs Theta on Setup1 : LastAdaptive, Infinite Sphere1 [Theta=0deg Phi=all Freq=60GHz]
  Gain Plot 10: dB(GainTotal) vs Theta on Setup1 : LastAdaptive, Infinite Sphere1 [Phi=all Freq=60GHz]
  Gain Plot 11: dB(GainTotal) vs Theta on Setup1 : LastAdaptive, Infinite Sphere1 [Phi=360deg Freq=60GHz]
  Gain Plot 12: dB(GainTotal) vs Theta on Setup1 : LastAdaptive, Infinite Sphere1 [Phi=0deg Freq=60GHz]
  Gain Plot 13: dB(GainTotal) vs Theta on Setup1 : LastAdaptive, Infinite Sphere1 [Phi=350deg Freq=60GHz]
  Gain Plot 14: dB(GainTotal) vs Theta on Setup1 : LastAdaptive, Infinite Sphere1 [Phi=180deg Freq=60GHz]
  Gain Plot 15: dB(GainTotal) vs Theta on Setup1 : LastAdaptive, Infinite Sphere1 [Phi=all Freq=60GHz]
  Gain Plot 16: dB(GainTotal) vs Phi on Setup1 : LastAdaptive, Infinite Sphere1 [Theta=180deg Freq=60GHz]
  Gain Plot 17: dB(GainTotal) vs Phi on Setup1 : LastAdaptive, Infinite Sphere1 [Theta=90deg Freq=60GHz]
  Gain Plot 18: dB(GainTotal) vs Phi on Setup1 : LastAdaptive, Infinite Sphere1 [Theta=0deg Freq=60GHz]
  Gain Plot 19: dB(GainTotal) vs Phi on Setup1 : LastAdaptive, Infinite Sphere1 [Theta=-180deg Freq=60GHz]
  Gain Plot 20: dB(GainTotal) vs Phi on Setup1 : LastAdaptive, Infinite Sphere1 [Theta=all Freq=60GHz]
  Gain Plot 21: dB(GainTotal) vs Phi on Setup1 : LastAdaptive, Infinite Sphere1 [Theta=-170deg Freq=60GHz]
  Gain Plot 22: dB(GainTotal) vs Phi on Setup1 : LastAdaptive, Infinite Sphere1 [Theta=-150deg Freq=60GHz]
  Gain Plot 23: dB(GainTotal) vs Phi on Setup1 : LastAdaptive, Infinite Sphere1 [Theta=-100deg Freq=60GHz]
  Gain Plot 24: dB(GainTotal) vs Phi on Setup1 : LastAdaptive, Infinite Sphere1 [Theta=-90deg Freq=60GHz]
  Gain Plot 25: dB(GainTotal) vs Phi on Setup1 : LastAdaptive, Infinite Sphere1 [Theta=-50deg Freq=60GHz]
  Gain Plot 26: dB(GainTotal) vs Phi on Setup1 : LastAdaptive, Infinite Sphere1 [Theta=-10deg Freq=60GHz]
  Gain Plot 27: dB(GainTotal) vs Phi on Setup1 : LastAdaptive, Infinite Sphere1 [Theta=0deg Freq=60GHz]
  Radiation Pattern at theta = 90': dB(GainTotal) vs Phi on Setup1 : LastAdaptive, Infinite Sphere1; markers m1 at 90deg, m2 at 180deg, m3 at 270deg, m4 at 360deg
