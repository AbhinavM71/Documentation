# Ansys Electronics Desktop project, version 2023.2
materials:
  vacuum: permittivity=1
  silicon: permittivity=11.9
  silicon_dioxide: permittivity=4
  Arlon CLTE-XT (tm): permittivity=2.94 dielectric_loss_tangent=0.0012
  air: permittivity=1.0006 permeability=1.0000004

design HFSSDesign1 (HFSS, HFSS Terminal Network, model units um)
geometry:
  Rectangle2 = rectangle(corner=(460um, 0um, 0um), x_size=3.8637um, y_size=3.8637um)
  Rectangle3 = rectangle(corner=(430um, -48um, 0um), x_size=60um, y_size=100um)
  Rectangle4 = rectangle(corner=(430um, -22um, 0um), x_size=33.8637um, y_size=48um)
  Rectangle3.subtract(Rectangle4)
  Box1 [silicon] = box(corner=(-2500um, -2500um, -664um), size=(5000um, 5000um, 663um))
  Box2 [silicon_dioxide] = box(corner=(-2500um, -2500um, -1um), size=(5000um, 5000um, 2um))
  Box3 [Arlon CLTE-XT (tm)] = box(corner=(-2600um, -3000um, -664um), size=(5505um, 6000um, 850um))
  Box4 [air] = box(corner=(-2900um, -3050um, -700um), size=(5900um, 6050um, 900um))
  Polyline1_2 = imported_body()
  Rectangle3.unite(Polyline1_2)
  coordinate_system RelativeCS1 = origin=(0um, 0um, 10000um) x=(1um, 0um, 0um) y=(0um, 1um, 0um)
  coordinate_system RelativeCS2 = origin=(0um, 0um, -10000um) x=(1um, 0um, 0um) y=(0um, 1um, 0um) in RelativeCS1
boundaries and excitations:
  Rad1: Radiation Objects=Box4
  PerfE1: Perfect E Objects=Rectangle3
  1: Lumped Port Objects=Rectangle2 LumpedPortType=Modal Modes{Mode1{IntLine{(463800000um, 1800000um, 0um) -> (460, 1.8, 0)} CharImp=Zpi}} Impedance=50ohm
setups:
  Setup1: HfssDriven Frequency=60GHz MaxDeltaS=0.02 MaximumPasses=6 MinimumPasses=1 MinimumConvergedPasses=1 PercentRefinement=30 BasisOrder=1 PortAccuracy=2 DrivenSolverType="Direct Solver"
    sweep Sweep: 30GHz to 90GHz, 401 points; Type=Discrete SaveFields SaveRadFields
source amplitudes:
  1:1: 1V 0deg
radiation setups:
  Infinite Sphere1: Infinite Sphere Theta=0deg..180deg step 2deg Phi=-180deg..180deg step 2deg
  Rectangle1: Near Rectangle  Length=20cm Width=20cm LengthSamples=41 WidthSamples=41 CoordSystem=RelativeCS1
  Rectangle2: Near Rectangle  Length=20cm Width=20cm LengthSamples=41 WidthSamples=41 CoordSystem=RelativeCS2
reports:
  On Si Gain Plot: dB(GainTotal) vs Freq on Setup1 : Sweep, Infinite Sphere1 [Phi=0deg Theta=0deg]; markers m1 at 60GHz
  OnSi S Parameter Plot: dB(S(1,1)) vs Freq on Setup1 : Sweep; markers m1 at 55.5GHz
  VSWR Plot 1: VSWR(1) vs Freq on Setup1 : Sweep
  Gain Plot 2: dB(GainTotal) vs Theta on Setup1 : LastAdaptive, Infinite Sphere1 [Phi=all Freq=60GHz]
  Gain Plot 3: dB(GainTotal) vs Theta on Setup1 : LastAdaptive, Infinite Sphere1 [Phi=0deg Freq=60GHz]
  Gain Plot 4: dB(GainTotal) vs Theta on Setup1 : LastAdaptive, Infinite Sphere1 [Theta=90deg Phi=all Freq=60GHz]
  System Gain Plot 1: dB(SystemGainTotal) vs Freq on Setup1 : Sweep, Infinite Sphere1 [Phi=0deg Theta=0deg]
  OnSi Gain Plot: dB(GainTotal) vs Phi, Theta on Setup1 : LastAdaptive, Infinite Sphere1 [Freq=60GHz]
  Near Poynting Plot 1: re(NearPoyntingZ) vs _u, _v on Setup1 : LastAdaptive [Freq=60GHz]
  Near Poynting Plot 2: dB(NearPoyntingTotal) vs _u on Setup1 : LastAdaptive [_v=all Freq=60GHz]
  Near Poynting Plot 3: re(NearPoyntingZ) vs _u on Setup1 : LastAdaptive [_v=all Freq=60GHz]
  power_element: re(NearPoyntingZ) vs _u, _v on Setup1 : LastAdaptive [Freq=60GHz]
  Power_in_DB: 10*log10(NearETotal*0.000025) vs _u, _v on Setup1 : LastAdaptive [Freq=60GHz]
  Power_in_mDb: re(NearPoyntingZ) vs _u, _v on Setup1 : LastAdaptive [Freq=60GHz]
  Near Poynting Plot 4_below: re(NearPoyntingZ) vs _u, _v on Setup1 : LastAdaptive [Freq=60GHz]
  Power Plot at plane z=10 cm: re(NearPoyntingZ)*0.000025 vs _u, _v on Setup1 : LastAdaptive [Freq=60GHz]
  Gain Plot 5: dB(GainTotal) vs Theta on Setup1 : LastAdaptive, Infinite Sphere1 [Phi=0deg Freq=60GHz]
  Gain Plot 6: dB(GainTotal) vs Theta on Setup1 : LastAdaptive, Infinite Sphere1 [Phi=90deg Freq=60GHz]
  Gain Plot 7: dB(GainTotal) vs Phi on Setup1 : LastAdaptive, Infinite Sphere1 [Theta=0deg Freq=60GHz]
  Gain Plot 8: dB(GainTotal) vs Phi on Setup1 : LastAdaptive, Infinite Sphere1 [Theta=90deg Freq=60GHz]
  Radiation Plot at theta = 0': dB(GainTotal) vs Phi on Setup1 : LastAdaptive, Infinite Sphere1; markers m1 at 0deg, m2 at 88deg, m3 at -180deg, m4 at -98deg, m5 at 0deg, m6 at 90deg, m7 at 180deg, m8 at -90deg
